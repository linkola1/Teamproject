# Ansys Electronics Desktop project, version 2018.2
materials:
  vacuum: permittivity=1
  copper: permeability=0.999991 conductivity=58000000
  air: permittivity=1.0006 permeability=1.0000004

design Maxwell3DDesign1 (Maxwell 3D, Magnetostatic, model units mm)
variables:
  distance1 = 20mm
geometry:
  Polygon1 [copper] = regular_polygon(axis=X, centre=(0mm, 5mm, 0mm), first_corner=(0mm, 6mm, 0mm), sides=8)
  Polygon1.spiral(IsSpiral XCenter=0mm YCenter=0mm ZCenter=0mm XStartDir=0mm YStartDir=0mm ZStartDir=1mm NumThread=10 RightHand=true RadiusIncrement=2.5mm)
  Polyline1 = polyline(x=0mm, yz in mm: (5, 1) (5, -5) (80, -5), section rectangle width=2mm height=2mm)
  Polyline2 = polyline((0mm, 29mm, 0mm) (0mm, 80mm, 0mm), section rectangle width=2mm height=2mm)
  Polygon2 [copper] = regular_polygon(axis=X, centre=(0mm, 5mm, distance1), first_corner=(0mm, 6mm, distance1), sides=8)
  Polygon2.spiral(IsSpiral XCenter=0mm YCenter=0mm ZCenter=0mm XStartDir=0mm YStartDir=0mm ZStartDir=1mm NumThread=10 RightHand=true RadiusIncrement=2.5mm)
  Polyline3 = polyline(x=0mm, yz: (5mm, -1mm+distance1) (5mm, 5mm+distance1) (80mm, 5mm+distance1), section rectangle width=2mm height=2mm)
  Polyline4 = polyline((0mm, 29mm, distance1) (0mm, 80mm, distance1), section rectangle width=2mm height=2mm)
  Polygon2.unite(Polyline3, Polyline4)
  Polygon1.unite(Polyline1, Polyline2)
  Box1 [air] = box(corner=(-70mm, -70mm, -50mm), size=(140mm, 150mm, 100mm))
boundaries and excitations:
  T1: Current Faces=Polygon1.face(5 of 6) Current=1.5A IsSolid=true Point_out_of_terminal=false
  T2: Current Faces=Polygon1.face(3 of 8) Current=1.5A IsSolid=true Point_out_of_terminal=true
  R2: Current Faces=Polygon2.face(3 of 8) Current=3A IsSolid=true Point_out_of_terminal=true
  R1: Current Faces=Polygon2.face(5 of 6) Current=3A IsSolid=true Point_out_of_terminal=false
parameters:
  Matrix1: Matrix T1, R1: NumberOfTurns=1
mesh:
  initial mesh: GlobalCurvilinear{Apply}
setups:
  Setup1: Magnetostatic MaximumPasses=10 MinimumPasses=2 MinimumConvergedPasses=1 PercentRefinement=30 PercentError=1 NonLinearResidual=0.001
optimetrics:
  ParametricSetup1: Parametric Sim._Setups=[Setup1]
    sweep distance1: LIN 5mm 30mm 5mm
field plots:
  energy1: Energy in Box1 on Setup1 : LastAdaptive
reports:
  Coupling Coeff Table 1: Matrix1.CplCoef(R1,R1), Matrix1.CplCoef(T1,R1), Matrix1.CplCoef(T1,T1), Matrix1.L(R1,R1), Matrix1.L(T1,R1), Matrix1.L(T1,T1) vs distance1 on Setup1 : LastAdaptive
